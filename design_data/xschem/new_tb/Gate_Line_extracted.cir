* Extracted by KLayout with SG13G2 LVS runset on : 13/09/2025 14:45

.SUBCKT Gate_Line ctrl_n ctrl_p
M$1 \$6 ctrl_n \$18 \$1 sg13_lv_nmos L=0.13u W=0.15u AS=0.1005p AD=0.1005p
+ PS=1.34u PD=1.34u
M$2 \$7 ctrl_p \$18 \$1 sg13_lv_nmos L=0.13u W=0.15u AS=0.1005p AD=0.1005p
+ PS=1.34u PD=1.34u
M$3 \$8 ctrl_p \$19 \$1 sg13_lv_nmos L=0.13u W=0.15u AS=0.1005p AD=0.1005p
+ PS=1.34u PD=1.34u
M$4 \$8 ctrl_p \$9 \$1 sg13_lv_nmos L=0.13u W=10u AS=3.4p AD=3.4p PS=20.68u
+ PD=20.68u
M$5 \$7 ctrl_n \$18 \$3 sg13_lv_pmos L=0.13u W=0.15u AS=0.1005p AD=0.1005p
+ PS=1.34u PD=1.34u
M$6 \$8 ctrl_n \$19 \$4 sg13_lv_pmos L=0.13u W=0.3u AS=0.102p AD=0.102p
+ PS=1.28u PD=1.28u
M$7 \$8 ctrl_n \$9 \$5 sg13_lv_pmos L=0.13u W=10u AS=3.4p AD=3.4p PS=20.68u
+ PD=20.68u
R$8 \$3 \$22 ntap1 A=0.6084p P=3.12u
R$9 \$4 \$22 ntap1 A=0.6084p P=3.12u
R$10 \$5 \$22 ntap1 A=7.8p P=21.56u
R$11 \$1 \$20 ptap1 A=9.6252p P=30.92u
.ENDS Gate_Line
